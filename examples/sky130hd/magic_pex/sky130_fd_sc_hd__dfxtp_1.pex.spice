* NGSPICE file created from sky130_fd_sc_hd__dfxtp_1.ext - technology: sky130A

.subckt sky130_fd_sc_hd__dfxtp_1 Q CLK D VPB VNB VPWR VGND
X0 Q.t0 a_1059_315.t5 VGND.t2 VNB.t11 sky130_fd_pr__nfet_01v8 ad=0.169 pd=1.82 as=0.08775 ps=0.92 w=0.65 l=0.15
X1 a_891_413.t0 a_193_47.t4 a_634_159.t0 VNB.t7 sky130_fd_pr__special_nfet_01v8 ad=0.0684 pd=0.74 as=0.0989 ps=0.995 w=0.36 l=0.15
X2 a_561_413.t0 a_27_47.t5 a_466_413.t3 VPB.t4 sky130_fd_pr__pfet_01v8_hvt ad=0.07665 pd=0.785 as=0.06825 ps=0.745 w=0.42 l=0.15
X3 VPWR.t0 CLK.t1 a_27_47.t1 VPB.t0 sky130_fd_pr__pfet_01v8_hvt ad=0.0864 pd=0.91 as=0.1664 ps=1.8 w=0.64 l=0.15
X4 Q.t1 a_1059_315.t4 VPWR.t2 VPB.t11 sky130_fd_pr__pfet_01v8_hvt ad=0.26 pd=2.52 as=0.135 ps=1.27 w=1 l=0.15
X5 a_381_47.t1 D.t1 VPWR.t1 VPB.t2 sky130_fd_pr__pfet_01v8_hvt ad=0.05775 pd=0.695 as=0.1092 ps=1.36 w=0.42 l=0.15
X6 VGND.t6 a_634_159.t5 a_592_47.t1 VNB.t5 sky130_fd_pr__nfet_01v8 ad=0.12095 pd=1.085 as=0.0696 ps=0.765 w=0.42 l=0.15
X7 VPWR.t7 a_891_413.t4 a_1059_315.t1 VPB.t10 sky130_fd_pr__pfet_01v8_hvt ad=0.135 pd=1.27 as=0.27 ps=2.54 w=1 l=0.15
X8 a_466_413.t0 a_193_47.t2 a_381_47.t2 VPB.t3 sky130_fd_pr__pfet_01v8_hvt ad=0.06825 pd=0.745 as=0.05775 ps=0.695 w=0.42 l=0.15
X9 VPWR.t6 a_634_159.t4 a_561_413.t1 VPB.t5 sky130_fd_pr__pfet_01v8_hvt ad=0.17887 pd=1.26 as=0.07665 ps=0.785 w=0.42 l=0.15
X10 a_634_159.t3 a_466_413.t5 VGND.t5 VNB.t6 sky130_fd_pr__nfet_01v8 ad=0.0989 pd=0.995 as=0.12095 ps=1.085 w=0.64 l=0.15
X11 a_634_159.t2 a_466_413.t4 VPWR.t5 VPB.t6 sky130_fd_pr__pfet_01v8_hvt ad=0.1095 pd=1.075 as=0.17887 ps=1.26 w=0.75 l=0.15
X12 a_975_413.t1 a_193_47.t5 a_891_413.t1 VPB.t8 sky130_fd_pr__pfet_01v8_hvt ad=0.0882 pd=0.84 as=0.0567 ps=0.69 w=0.42 l=0.15
X13 VGND.t3 a_1059_315.t3 a_1017_47.t0 VNB.t9 sky130_fd_pr__nfet_01v8 ad=0.1092 pd=1.36 as=0.066 ps=0.745 w=0.42 l=0.15
X14 a_193_47.t0 a_27_47.t2 VGND.t4 VNB.t1 sky130_fd_pr__nfet_01v8 ad=0.1092 pd=1.36 as=0.0567 ps=0.69 w=0.42 l=0.15
X15 a_891_413.t2 a_27_47.t6 a_634_159.t1 VPB.t7 sky130_fd_pr__pfet_01v8_hvt ad=0.0567 pd=0.69 as=0.1095 ps=1.075 w=0.42 l=0.15
X16 a_592_47.t0 a_193_47.t3 a_466_413.t1 VNB.t4 sky130_fd_pr__special_nfet_01v8 ad=0.0696 pd=0.765 as=0.0621 ps=0.705 w=0.36 l=0.15
X17 VPWR.t3 a_1059_315.t2 a_975_413.t0 VPB.t9 sky130_fd_pr__pfet_01v8_hvt ad=0.1113 pd=1.37 as=0.0882 ps=0.84 w=0.42 l=0.15
X18 a_1017_47.t1 a_27_47.t7 a_891_413.t3 VNB.t8 sky130_fd_pr__special_nfet_01v8 ad=0.066 pd=0.745 as=0.0684 ps=0.74 w=0.36 l=0.15
X19 a_193_47.t1 a_27_47.t3 VPWR.t4 VPB.t1 sky130_fd_pr__pfet_01v8_hvt ad=0.1664 pd=1.8 as=0.0864 ps=0.91 w=0.64 l=0.15
X20 a_466_413.t2 a_27_47.t4 a_381_47.t3 VNB.t3 sky130_fd_pr__special_nfet_01v8 ad=0.0621 pd=0.705 as=0.0813 ps=0.83 w=0.36 l=0.15
X21 VGND.t7 a_891_413.t5 a_1059_315.t0 VNB.t10 sky130_fd_pr__nfet_01v8 ad=0.08775 pd=0.92 as=0.169 ps=1.82 w=0.65 l=0.15
X22 a_381_47.t0 D.t0 VGND.t1 VNB.t2 sky130_fd_pr__nfet_01v8 ad=0.0813 pd=0.83 as=0.1092 ps=1.36 w=0.42 l=0.15
X23 VGND.t0 CLK.t0 a_27_47.t0 VNB.t0 sky130_fd_pr__nfet_01v8 ad=0.0567 pd=0.69 as=0.1092 ps=1.36 w=0.42 l=0.15
R0 a_975_413.t0 a_975_413.t1 197
R1 a_891_413.t1 a_891_413.t2 132.404
R2 a_891_413.t1 a_891_413.n0 1455.44
R3 a_891_413.t2 a_891_413.n0 1455.44
R4 a_891_413.t4 a_891_413.t5 472.702
R5 a_891_413.t4 a_891_413.n0 839.758
R6 a_891_413.t5 a_891_413.n0 559.26
R7 a_891_413.t3 a_891_413.t0 141.48
R8 a_891_413.t3 a_891_413.n0 732.264
R9 a_891_413.t0 a_891_413.n0 477.563
R10 a_634_159.t0 a_634_159.t3 109.629
R11 a_634_159.t0 a_634_159.n0 824.938
R12 a_634_159.t3 a_634_159.n0 327.337
R13 a_634_159.t4 a_634_159.t5 829.823
R14 a_634_159.t4 a_634_159.n0 1149.54
R15 a_634_159.t5 a_634_159.n0 367.868
R16 a_634_159.t1 a_634_159.t2 131.605
R17 a_634_159.t1 a_634_159.n0 2363.91
R18 a_634_159.t2 a_634_159.n0 995.332
R19 a_592_47.t0 a_592_47.t1 99.7268
R20 a_561_413.t0 a_561_413.t1 171.202
R21 a_466_413.t4 a_466_413.t5 694.236
R22 a_466_413.t4 a_466_413.n0 508.255
R23 a_466_413.t5 a_466_413.n0 597.635
R24 a_466_413.t1 a_466_413.t2 125.558
R25 a_466_413.t1 a_466_413.n0 832.479
R26 a_466_413.t2 a_466_413.n0 535.165
R27 a_466_413.t3 a_466_413.t0 160.774
R28 a_466_413.t3 a_466_413.n0 1402.68
R29 a_466_413.t0 a_466_413.n0 1538.43
R30 a_381_47.n0 a_381_47.t3 90.0005
R31 a_381_47.t2 a_381_47.t1 133.627
R32 a_381_47.t2 a_381_47.n0 1891.47
R33 a_381_47.t1 a_381_47.n0 1823.92
R34 a_381_47.n0 a_381_47.n1 22.1285
R35 a_381_47.n0 a_381_47.t0 40.5577
R36 a_381_47.n1 a_381_47.t0 116.805
R37 a_27_47.n0 a_27_47.t0 287.998
R38 a_27_47.t3 a_27_47.t2 885.453
R39 a_27_47.t3 a_27_47.n0 590.755
R40 a_27_47.t2 a_27_47.n0 511.411
R41 a_27_47.t6 a_27_47.t7 1280.54
R42 a_27_47.t6 a_27_47.n1 559.037
R43 a_27_47.t7 a_27_47.n1 974.489
R44 a_27_47.n1 a_27_47.t4 372.209
R45 a_27_47.n1 a_27_47.t5 320.108
R46 a_27_47.t4 a_27_47.t5 8885.64
R47 a_27_47.t1 a_27_47.n0 1670.21
R48 a_27_47.t1 a_27_47.n1 523.37
R49 a_27_47.n0 a_27_47.n1 47.4166
R50 a_193_47.t5 a_193_47.t4 8651.04
R51 a_193_47.t5 a_193_47.n0 331.943
R52 a_193_47.t4 a_193_47.n0 320.889
R53 a_193_47.t2 a_193_47.t3 1332.65
R54 a_193_47.t2 a_193_47.n0 559.284
R55 a_193_47.t3 a_193_47.n0 832.505
R56 a_193_47.t1 a_193_47.t0 11937.8
R57 a_193_47.t1 a_193_47.n0 416.447
R58 a_193_47.t0 a_193_47.n0 312.096
R59 a_1059_315.t1 a_1059_315.n1 226.315
R60 a_1059_315.n0 a_1059_315.t0 149.642
R61 a_1059_315.n1 a_1059_315.n0 16.6232
R62 a_1059_315.t4 a_1059_315.t5 645.808
R63 a_1059_315.t4 a_1059_315.n0 663.665
R64 a_1059_315.t5 a_1059_315.n0 465.007
R65 a_1059_315.t2 a_1059_315.t3 826.369
R66 a_1059_315.t2 a_1059_315.n1 375.219
R67 a_1059_315.t3 a_1059_315.n1 1036.69
R68 a_1017_47.t0 a_1017_47.t1 93.0601
R69 VPWR.t4 VPWR.t0 85.94
R70 VPWR.t2 VPWR.t7 55.2512
R71 VPWR VPWR.t3 676.564
R72 VPWR.t7 VPWR 714.418
R73 VPWR.t2 VPWR 714.418
R74 VPWR VPWR.t1 672.912
R75 VPWR VPWR.t5 472.615
R76 VPWR VPWR.t6 1519.12
R77 VPWR.t5 VPWR.t6 161.56
R78 VPWR.t0 VPWR 1262.49
R79 VPWR.t4 VPWR 1262.49
R80 VPB.t9 VPB.t10 621.495
R81 VPB.t1 VPB.t2 556.386
R82 VPB.t5 VPB.t6 390.654
R83 VPB.t8 VPB.t9 337.384
R84 VPB.t4 VPB.t5 304.829
R85 VPB.t3 VPB.t4 281.154
R86 VPB.t6 VPB.t7 281.154
R87 VPB.t2 VPB.t3 251.559
R88 VPB.t0 VPB.t1 248.599
R89 VPB.t7 VPB.t8 248.599
R90 VPB.t10 VPB.t11 248.599
R91 VPB VPB.t0 192.369
R92 VNB.t9 VNB.t10 2691.26
R93 VNB.t1 VNB.t2 2677.02
R94 VNB.t5 VNB.t6 1694.5
R95 VNB.t2 VNB.t3 1594.82
R96 VNB.t7 VNB.t8 1509.39
R97 VNB.t6 VNB.t7 1438.19
R98 VNB.t3 VNB.t4 1409.71
R99 VNB.t4 VNB.t5 1409.71
R100 VNB.t8 VNB.t9 1352.75
R101 VNB.t0 VNB.t1 1196.12
R102 VNB.t10 VNB.t11 1196.12
R103 VNB VNB.t0 925.567
R104 VGND.n0 VGND.t7 24.9236
R105 VGND.n0 VGND.t2 24.9236
R106 VGND VGND.n0 229.177
R107 VGND.t5 VGND.t6 129.487
R108 VGND.n0 VGND.t3 43118.5
R109 VGND.t3 VGND 259.401
R110 VGND.t4 VGND.t0 84.3832
R111 VGND.t6 VGND 354.675
R112 VGND.t5 VGND 663.827
R113 VGND.t0 VGND 450.163
R114 VGND.t4 VGND 450.163
R115 VGND VGND.t1 249.303
R116 Q.t1 Q 339.69
R117 Q.t1 Q.t0 7507.49
R118 Q Q.t0 137.279
R119 D.t1 D.t0 894.229
R120 D.t1 D 502.329
R121 D.t0 D 714.76
R122 CLK.t1 CLK.t0 909.242
R123 CLK.t1 CLK 663.457
R124 CLK.t0 CLK 475.276
C0 a_975_413.t1 a_891_413.n0 0.00823f
C1 a_975_413.t1 a_634_159.n0 0.00116f
C2 a_975_413.t1 a_193_47.n0 0
C3 a_975_413.t1 VPWR 0.00473f
C4 a_975_413.t1 VGND 0
C5 a_891_413.n0 a_634_159.n0 0.03593f
C6 a_891_413.n0 a_27_47.n1 0.03015f
C7 a_891_413.n0 a_193_47.n0 0.20494f
C8 a_891_413.n0 a_1059_315.n1 0.29189f
C9 a_891_413.n0 a_1017_47.t0 0.00593f
C10 a_891_413.n0 VPB 0.06393f
C11 a_891_413.n0 VPWR 0.1113f
C12 a_891_413.n0 VGND 0.12339f
C13 a_891_413.n0 Q 0.00187f
C14 a_634_159.n0 a_592_47.t1 0
C15 a_634_159.n0 a_466_413.n0 0.22437f
C16 a_634_159.n0 a_381_47.n0 0
C17 a_634_159.n0 a_27_47.n1 0.13893f
C18 a_634_159.n0 a_193_47.n0 0.1158f
C19 a_634_159.n0 a_1059_315.n1 0
C20 a_634_159.n0 a_1017_47.t0 0
C21 a_634_159.n0 VPB 0.07034f
C22 a_634_159.n0 VPWR 0.10423f
C23 a_634_159.n0 VGND 0.12337f
C24 a_592_47.t1 a_466_413.n0 0.00515f
C25 a_592_47.t1 a_193_47.n0 0.00123f
C26 a_592_47.t1 VGND 0.00737f
C27 a_561_413.t1 a_466_413.n0 0.00737f
C28 a_561_413.t1 a_381_47.n0 0.00122f
C29 a_561_413.t1 a_27_47.n1 0.00247f
C30 a_561_413.t1 VPWR 0.00369f
C31 a_466_413.n0 a_381_47.n0 0.0358f
C32 a_466_413.n0 a_27_47.n1 0.2729f
C33 a_466_413.n0 a_193_47.n0 0.07753f
C34 a_466_413.n0 VPB 0.07004f
C35 a_466_413.n0 VPWR 0.17454f
C36 a_466_413.n0 VGND 0.08611f
C37 a_381_47.n0 a_27_47.n1 0.05849f
C38 a_381_47.n0 a_193_47.n0 0.10003f
C39 a_381_47.n0 VPB 0.01412f
C40 a_381_47.n0 D 0.11445f
C41 a_381_47.n0 VPWR 0.06299f
C42 a_381_47.n0 VGND 0.05289f
C43 a_27_47.n1 a_193_47.n0 0.96326f
C44 a_27_47.n1 a_1059_315.n1 0.04022f
C45 a_27_47.n1 VPB 0.22675f
C46 a_27_47.n1 CLK 0.2097f
C47 a_27_47.n1 D 0.05309f
C48 a_27_47.n1 VPWR 0.38555f
C49 a_27_47.n1 VGND 0.13273f
C50 a_27_47.n1 Q 0
C51 a_193_47.n0 a_1059_315.n1 0.0294f
C52 a_193_47.n0 VPB 0.1599f
C53 a_193_47.n0 CLK 0.00321f
C54 a_193_47.n0 D 0.17279f
C55 a_193_47.n0 VPWR 0.11932f
C56 a_193_47.n0 VGND 0.20256f
C57 a_193_47.n0 Q 0
C58 a_1059_315.n1 a_1017_47.t0 0
C59 a_1059_315.n1 VPB 0.13771f
C60 a_1059_315.n1 VPWR 0.233f
C61 a_1059_315.n1 VGND 0.1508f
C62 a_1059_315.n1 Q 0.07733f
C63 a_1017_47.t0 VPWR 0
C64 a_1017_47.t0 VGND 0.00508f
C65 VPB CLK 0.06196f
C66 VPB D 0.08649f
C67 VPB VPWR 0.18357f
C68 VPB VGND 0.01111f
C69 VPB Q 0.01229f
C70 CLK VPWR 0.01738f
C71 CLK VGND 0.01747f
C72 D VPWR 0.02316f
C73 D VGND 0.03882f
C74 VPWR VGND 0.06317f
C75 VPWR Q 0.1136f
C76 VGND Q 0.07716f
C77 Q VNB 0.03846f
C78 VGND VNB 0.64626f
C79 VPWR VNB 0.4796f
C80 D VNB 0.04695f
C81 CLK VNB 0.06507f
C82 VPB VNB 0.09582f
C83 CLK.t1 VNB 0.04036f
C84 CLK.t0 VNB 0.03671f
C85 D.t1 VNB 0.02472f
C86 D.t0 VNB 0.02386f
C87 Q.t1 VNB 0.02708f
C88 Q.t0 VNB 0.01118f
C89 VGND.t1 VNB 0.01318f
C90 VGND.t5 VNB 0.01789f
C91 VGND.t6 VNB 0.01178f
C92 VGND.t3 VNB 0.01378f
C93 VGND.t2 VNB 0.00527f
C94 VGND.t7 VNB 0.00527f
C95 VGND.n0 VNB 0.01321f
C96 VGND.t4 VNB 0.0073f
C97 VGND.t0 VNB 0.0073f
C98 VPB.t11 VNB 0.17719f
C99 VPB.t10 VNB 0.14156f
C100 VPB.t9 VNB 0.15601f
C101 VPB.t8 VNB 0.09534f
C102 VPB.t7 VNB 0.08619f
C103 VPB.t6 VNB 0.1093f
C104 VPB.t5 VNB 0.11315f
C105 VPB.t4 VNB 0.09533f
C106 VPB.t3 VNB 0.08667f
C107 VPB.t2 VNB 0.13145f
C108 VPB.t1 VNB 0.13097f
C109 VPB.t0 VNB 0.07174f
C110 VPWR.t4 VNB 0.00766f
C111 VPWR.t0 VNB 0.00766f
C112 VPWR.t1 VNB 0.00926f
C113 VPWR.t5 VNB 0.01793f
C114 VPWR.t6 VNB 0.01329f
C115 VPWR.t3 VNB 0.00958f
C116 VPWR.t2 VNB 0.01262f
C117 VPWR.t7 VNB 0.01262f
C118 a_1059_315.t0 VNB 0.01076f
C119 a_1059_315.t4 VNB 0.01342f
C120 a_1059_315.t5 VNB 0.01182f
C121 a_1059_315.n0 VNB 0.03698f
C122 a_1059_315.t2 VNB 0.01387f
C123 a_1059_315.t3 VNB 0.01253f
C124 a_1059_315.n1 VNB 0.04291f
C125 a_1059_315.t1 VNB 0.01695f
C126 a_193_47.t0 VNB 0.00954f
C127 a_193_47.t5 VNB 0.01142f
C128 a_193_47.t4 VNB 0.01263f
C129 a_193_47.t2 VNB 0.01302f
C130 a_193_47.t3 VNB 0.01335f
C131 a_193_47.n0 VNB 0.11799f
C132 a_193_47.t1 VNB 0.01132f
C133 a_27_47.t0 VNB 0.01133f
C134 a_27_47.t3 VNB 0.01597f
C135 a_27_47.t2 VNB 0.0145f
C136 a_27_47.n0 VNB 0.04163f
C137 a_27_47.t6 VNB 0.01771f
C138 a_27_47.t7 VNB 0.01821f
C139 a_27_47.t4 VNB 0.01703f
C140 a_27_47.t5 VNB 0.01475f
C141 a_27_47.n1 VNB 0.1335f
C142 a_27_47.t1 VNB 0.01441f
C143 a_381_47.t3 VNB 0
C144 a_381_47.t2 VNB 0.00186f
C145 a_381_47.t1 VNB 0.00189f
C146 a_381_47.n0 VNB 0.00648f
C147 a_381_47.t0 VNB 0
C148 a_381_47.n1 VNB 0
C149 a_466_413.t3 VNB 0.00447f
C150 a_466_413.t4 VNB 0.01118f
C151 a_466_413.t5 VNB 0.01091f
C152 a_466_413.t1 VNB 0.00475f
C153 a_466_413.t2 VNB 0.00544f
C154 a_466_413.n0 VNB 0.04234f
C155 a_466_413.t0 VNB 0.00442f
C156 a_634_159.t1 VNB 0.00502f
C157 a_634_159.t0 VNB 0.00427f
C158 a_634_159.t3 VNB 0.00803f
C159 a_634_159.t4 VNB 0.01136f
C160 a_634_159.t5 VNB 0.01213f
C161 a_634_159.n0 VNB 0.04186f
C162 a_634_159.t2 VNB 0.00964f
C163 a_891_413.t3 VNB 0.00535f
C164 a_891_413.t1 VNB 0.00467f
C165 a_891_413.t2 VNB 0.00467f
C166 a_891_413.t4 VNB 0.016f
C167 a_891_413.t5 VNB 0.01612f
C168 a_891_413.n0 VNB 0.05801f
C169 a_891_413.t0 VNB 0.00569f
.ends
