* NGSPICE file created from sky130_fd_sc_hd__inv_1.ext - technology: sky130A

.subckt sky130_fd_sc_hd__inv_1 VPB VNB VGND VPWR A Y
X0 Y.t0 A.t0 VGND.t0 VNB.t0 sky130_fd_pr__nfet_01v8 ad=0.169 pd=1.82 as=0.169 ps=1.82 w=0.65 l=0.15
X1 Y.t1 A.t1 VPWR.t0 VPB.t0 sky130_fd_pr__pfet_01v8_hvt ad=0.26 pd=2.52 as=0.26 ps=2.52 w=1 l=0.15
R0 Y Y.t1 235.56
R1 Y Y.t0 153.804
R2 VPWR VPWR.t0 264.904
R3 VPB VPB.t0 350.853
R4 VNB VNB.t0 1612.5
R5 VGND VGND.t0 166.951
R6 A.t1 A.t0 618.857
R7 A.t1 A 620.388
R8 A.t0 A 425.858
C0 VPB A 0.03924f
C1 VPB VPWR 0.06025f
C2 VPB Y 0.01569f
C3 VPB VGND 0.0116f
C4 A VPWR 0.04334f
C5 A Y 0.0459f
C6 A VGND 0.04586f
C7 VPWR Y 0.13297f
C8 VPWR VGND 0.03268f
C9 Y VGND 0.1035f
C10 VGND VNB 0.18524f
C11 Y VNB 0.05141f
C12 VPWR VNB 0.14435f
C13 A VNB 0.03299f
C14 VPB VNB 0.12672f
C15 A.t1 VNB 0.04346f
C16 A.t0 VNB 0.0398f
C17 VGND.t0 VNB 0.03131f
C18 VPB.t0 VNB 0.21226f
C19 VPWR.t0 VNB 0.03632f
C20 Y.t1 VNB 0.01951f
C21 Y.t0 VNB 0.01271f
.ends
