* NGSPICE file created from sky130_fd_sc_hd__xor2_1.ext - technology: sky130A

.subckt sky130_fd_sc_hd__xor2_1 VNB VPB VPWR VGND A X B
X0 X.t2 a_35_297.t4 a_285_297.t2 VPB.t4 sky130_fd_pr__pfet_01v8_hvt ad=0.3 pd=2.6 as=0.26 ps=2.52 w=1 l=0.15
X1 X.t0 B.t2 a_285_47.t1 VNB.t3 sky130_fd_pr__nfet_01v8 ad=0.25025 pd=1.42 as=0.08775 ps=0.92 w=0.65 l=0.15
X2 a_35_297.t1 B.t0 VGND.t2 VNB.t0 sky130_fd_pr__nfet_01v8 ad=0.08775 pd=0.92 as=0.169 ps=1.82 w=0.65 l=0.15
X3 a_117_297.t1 B.t1 a_35_297.t2 VPB.t0 sky130_fd_pr__pfet_01v8_hvt ad=0.135 pd=1.27 as=0.26 ps=2.52 w=1 l=0.15
X4 VPWR.t2 B.t3 a_285_297.t1 VPB.t3 sky130_fd_pr__pfet_01v8_hvt ad=0.26 pd=2.52 as=0.135 ps=1.27 w=1 l=0.15
X5 VGND.t0 A.t0 a_35_297.t0 VNB.t1 sky130_fd_pr__nfet_01v8 ad=0.08775 pd=0.92 as=0.08775 ps=0.92 w=0.65 l=0.15
X6 VGND.t3 a_35_297.t3 X.t1 VNB.t4 sky130_fd_pr__nfet_01v8 ad=0.208 pd=1.94 as=0.25025 ps=1.42 w=0.65 l=0.15
X7 a_285_297.t0 A.t3 VPWR.t1 VPB.t2 sky130_fd_pr__pfet_01v8_hvt ad=0.135 pd=1.27 as=0.135 ps=1.27 w=1 l=0.15
X8 VPWR.t0 A.t1 a_117_297.t0 VPB.t1 sky130_fd_pr__pfet_01v8_hvt ad=0.135 pd=1.27 as=0.135 ps=1.27 w=1 l=0.15
X9 a_285_47.t0 A.t2 VGND.t1 VNB.t2 sky130_fd_pr__nfet_01v8 ad=0.08775 pd=0.92 as=0.08775 ps=0.92 w=0.65 l=0.15
R0 a_35_297.t2 a_35_297.n0 442.868
R1 a_35_297.t0 a_35_297.t1 53.005
R2 a_35_297.t0 a_35_297.n0 418.264
R3 a_35_297.t1 a_35_297.n0 418.264
R4 a_35_297.t3 a_35_297.t4 442.841
R5 a_35_297.t3 a_35_297.n0 706.801
R6 a_35_297.t4 a_35_297.n0 1089.59
R7 a_285_47.t0 a_285_47.t1 49.8467
R8 a_285_297.t1 a_285_297.t2 1349.82
R9 a_285_297.t1 a_285_297.t0 54.2595
R10 a_285_297.t2 a_285_297.t0 1349.82
R11 a_117_297.t0 a_117_297.t1 53.1905
R12 X X.t2 235.792
R13 X.t1 X 388.517
R14 X.t1 X.t0 147.549
R15 X X.t0 434.228
R16 VPWR VPWR.t2 852.101
R17 VPWR.t1 VPWR.t0 55.3255
R18 VPWR.t1 VPWR 689.165
R19 VPWR.t0 VPWR 689.165
R20 VPB.t3 VPB.t4 556.386
R21 VPB.t2 VPB.t3 248.599
R22 VPB.t1 VPB.t2 248.599
R23 VPB.t0 VPB.t1 248.599
R24 VPB VPB.t0 216.044
R25 VNB.t3 VNB.t4 2620.06
R26 VNB.t2 VNB.t3 1196.12
R27 VNB.t1 VNB.t2 1196.12
R28 VNB.t0 VNB.t1 1196.12
R29 VNB VNB.t0 1039.48
R30 VGND VGND.t3 152.428
R31 VGND.t1 VGND.t0 52.8623
R32 VGND.t2 VGND 285.947
R33 VGND.t0 VGND 437.656
R34 VGND.t1 VGND 437.656
R35 B B.t3 853.706
R36 B B.t2 598.162
R37 B.t3 B.t2 572.845
R38 B.t1 B.t0 655.702
R39 B.t1 B 646.614
R40 B.t0 B 453.06
R41 A A.n0 153.28
R42 A.t3 A.t2 1147.78
R43 A.t3 A.n0 305.837
R44 A.t2 A.n0 201.575
R45 A.t1 A.t0 1581.92
R46 A.t1 A.n0 272.747
R47 A.t0 A.n0 179.764
C0 a_35_297.n0 a_285_47.t1 0.0073f
C1 a_35_297.n0 a_285_297.t2 0.02161f
C2 a_35_297.n0 a_117_297.t1 0.00576f
C3 a_35_297.n0 VPB 0.06125f
C4 a_35_297.n0 B 0.19859f
C5 a_35_297.n0 A 0.06076f
C6 a_35_297.n0 VPWR 0.09081f
C7 a_35_297.n0 X 0.16828f
C8 a_35_297.n0 VGND 0.17454f
C9 a_285_47.t1 B 0
C10 a_285_47.t1 VPWR 0
C11 a_285_47.t1 X 0.00185f
C12 a_285_47.t1 VGND 0.00674f
C13 a_285_297.t2 VPB 0.01202f
C14 a_285_297.t2 B 0.05398f
C15 a_285_297.t2 A 0.00668f
C16 a_285_297.t2 VPWR 0.25323f
C17 a_285_297.t2 X 0.07264f
C18 a_285_297.t2 VGND 0.00355f
C19 a_117_297.t1 B 0.00721f
C20 a_117_297.t1 VPWR 0.01292f
C21 a_117_297.t1 X 0
C22 a_117_297.t1 VGND 0.00159f
C23 VPB B 0.06226f
C24 VPB A 0.04499f
C25 VPB VPWR 0.07779f
C26 VPB X 0.01438f
C27 VPB VGND 0.00618f
C28 B A 0.21301f
C29 B VPWR 0.06621f
C30 B X 0.01268f
C31 B VGND 0.02764f
C32 A VPWR 0.03594f
C33 A X 0.00145f
C34 A VGND 0.02981f
C35 VPWR X 0.05288f
C36 VPWR VGND 0.06488f
C37 X VGND 0.17257f
C38 VGND VNB 0.31284f
C39 X VNB 0.02225f
C40 VPWR VNB 0.22814f
C41 A VNB 0.01023f
C42 B VNB 0.04837f
C43 VPB VNB 0.09967f
C44 A.t3 VNB 0.01517f
C45 A.t2 VNB 0.01202f
C46 A.t1 VNB 0.01459f
C47 A.t0 VNB 0.01112f
C48 A.n0 VNB 0.02597f
C49 B.t3 VNB 0.02197f
C50 B.t2 VNB 0.02048f
C51 B.t1 VNB 0.0196f
C52 B.t0 VNB 0.0171f
C53 VGND.t3 VNB 0.02746f
C54 VGND.t1 VNB 0.01122f
C55 VGND.t0 VNB 0.01122f
C56 VGND.t2 VNB 0.0198f
C57 VPB.t4 VNB 0.22534f
C58 VPB.t3 VNB 0.13097f
C59 VPB.t2 VNB 0.08089f
C60 VPB.t1 VNB 0.08089f
C61 VPB.t0 VNB 0.07559f
C62 VPWR.t1 VNB 0.01369f
C63 VPWR.t0 VNB 0.01369f
C64 VPWR.t2 VNB 0.02341f
C65 X.t1 VNB 0.01038f
C66 X.t0 VNB 0.01054f
C67 X.t2 VNB 0.01031f
C68 a_285_297.t1 VNB 0
C69 a_285_297.t2 VNB 0
C70 a_285_297.t0 VNB 0
C71 a_35_297.t0 VNB 0.00841f
C72 a_35_297.t1 VNB 0.00841f
C73 a_35_297.t3 VNB 0.02716f
C74 a_35_297.t4 VNB 0.02538f
C75 a_35_297.n0 VNB 0.08659f
C76 a_35_297.t2 VNB 0.03452f
.ends
