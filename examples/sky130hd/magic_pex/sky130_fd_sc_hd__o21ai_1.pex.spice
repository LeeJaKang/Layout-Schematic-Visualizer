* NGSPICE file created from sky130_fd_sc_hd__o21ai_1.ext - technology: sky130A

.subckt sky130_fd_sc_hd__o21ai_1 VGND VPWR A2 B1 Y A1 VPB VNB
X0 Y.t0 A2.t0 a_109_297.t1 VPB.t1 sky130_fd_pr__pfet_01v8_hvt ad=0.174 pd=1.39 as=0.105 ps=1.21 w=1 l=0.15
X1 VPWR.t1 B1.t1 Y.t2 VPB.t2 sky130_fd_pr__pfet_01v8_hvt ad=0.182 pd=1.92 as=0.174 ps=1.39 w=0.7 l=0.15
X2 a_27_47.t1 A2.t1 VGND.t1 VNB.t1 sky130_fd_pr__nfet_01v8 ad=0.08775 pd=0.92 as=0.10725 ps=0.98 w=0.65 l=0.15
X3 Y.t1 B1.t0 a_27_47.t2 VNB.t2 sky130_fd_pr__nfet_01v8 ad=0.169 pd=1.82 as=0.08775 ps=0.92 w=0.65 l=0.15
X4 a_109_297.t0 A1.t1 VPWR.t0 VPB.t0 sky130_fd_pr__pfet_01v8_hvt ad=0.105 pd=1.21 as=0.26 ps=2.52 w=1 l=0.15
X5 VGND.t0 A1.t0 a_27_47.t0 VNB.t0 sky130_fd_pr__nfet_01v8 ad=0.10725 pd=0.98 as=0.169 ps=1.82 w=0.65 l=0.15
R0 a_27_47.t2 a_27_47.t1 51.1635
R1 a_27_47.t2 a_27_47.t0 968.307
R2 a_27_47.t1 a_27_47.t0 968.307
R3 a_109_297.t0 a_109_297.t1 41.3705
R4 Y Y.t1 305.245
R5 Y.t2 Y 582.803
R6 Y.t2 Y.t0 112.284
R7 Y Y.t0 714.163
R8 VPWR VPWR.t1 361.24
R9 VPWR VPWR.t0 251.102
R10 VPB.t1 VPB.t2 319.627
R11 VPB.t0 VPB.t1 213.084
R12 VPB VPB.t0 189.409
R13 VNB.t0 VNB.t1 1366.99
R14 VNB.t1 VNB.t2 1196.12
R15 VNB VNB.t0 911.327
R16 VGND.t1 VGND.t0 65.3042
R17 VGND.t1 VGND 371.538
R18 VGND.t0 VGND 536.667
R19 B1.t1 B1.t0 735.324
R20 B1.t1 B1 447.308
R21 B1.t0 B1 625.045
R22 A2 A2.t0 634.311
R23 A2 A2.t1 443.608
R24 A2.t0 A2.t1 658.213
R25 A1.t1 A1.t0 636.163
R26 A1.t1 A1 622.846
R27 A1.t0 A1 430.798
C0 a_27_47.t0 a_109_297.t1 0
C1 a_27_47.t0 VPB 0
C2 a_27_47.t0 A1 0.03556f
C3 a_27_47.t0 A2 0.03906f
C4 a_27_47.t0 B1 0.00411f
C5 a_27_47.t0 VPWR 0.00547f
C6 a_27_47.t0 Y 0.05227f
C7 a_27_47.t0 VGND 0.14329f
C8 a_109_297.t1 A2 0.00991f
C9 a_109_297.t1 VPWR 0.00407f
C10 a_109_297.t1 Y 0
C11 a_109_297.t1 VGND 0
C12 VPB A1 0.02862f
C13 VPB A2 0.0269f
C14 VPB B1 0.06609f
C15 VPB VPWR 0.05558f
C16 VPB Y 0.00614f
C17 VPB VGND 0.00409f
C18 A1 A2 0.09415f
C19 A1 VPWR 0.04829f
C20 A1 Y 0
C21 A1 VGND 0.01472f
C22 A2 B1 0.0406f
C23 A2 VPWR 0.10907f
C24 A2 Y 0.12582f
C25 A2 VGND 0.01662f
C26 B1 VPWR 0.04463f
C27 B1 Y 0.07985f
C28 B1 VGND 0.0143f
C29 VPWR Y 0.10481f
C30 VPWR VGND 0.03817f
C31 Y VGND 0.02703f
C32 VGND VNB 0.19179f
C33 Y VNB 0.02354f
C34 VPWR VNB 0.18411f
C35 B1 VNB 0.03281f
C36 A2 VNB 0.02884f
C37 A1 VNB 0.02656f
C38 VPB VNB 0.0963f
C39 A1.t1 VNB 0.03447f
C40 A1.t0 VNB 0.03083f
C41 A2.t0 VNB 0.01439f
C42 A2.t1 VNB 0.01257f
C43 B1.t1 VNB 0.0359f
C44 B1.t0 VNB 0.03407f
C45 VGND.t1 VNB 0.01623f
C46 VGND.t0 VNB 0.01607f
C47 VPB.t2 VNB 0.17912f
C48 VPB.t1 VNB 0.08667f
C49 VPB.t0 VNB 0.06548f
C50 VPWR.t1 VNB 0.01969f
C51 VPWR.t0 VNB 0.0299f
C52 Y.t1 VNB 0.00893f
C53 Y.t2 VNB 0.00652f
C54 Y.t0 VNB 0.0079f
C55 a_27_47.t2 VNB 0.00657f
C56 a_27_47.t1 VNB 0.00657f
C57 a_27_47.t0 VNB 0.01248f
.ends
