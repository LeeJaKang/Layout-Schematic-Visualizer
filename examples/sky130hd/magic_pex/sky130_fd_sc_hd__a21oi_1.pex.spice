* NGSPICE file created from sky130_fd_sc_hd__a21oi_1.ext - technology: sky130A

.subckt sky130_fd_sc_hd__a21oi_1 VPWR VGND VPB VNB A2 A1 B1 Y
X0 a_199_47.t0 A1.t0 Y.t0 VNB.t1 sky130_fd_pr__nfet_01v8 ad=0.09588 pd=0.945 as=0.091 ps=0.93 w=0.65 l=0.15
X1 a_113_297.t1 A2.t1 VPWR.t1 VPB.t2 sky130_fd_pr__pfet_01v8_hvt ad=0.265 pd=2.53 as=0.1475 ps=1.295 w=1 l=0.15
X2 Y.t1 B1.t0 VGND.t1 VNB.t0 sky130_fd_pr__nfet_01v8 ad=0.091 pd=0.93 as=0.17225 ps=1.83 w=0.65 l=0.15
X3 VPWR.t0 A1.t1 a_113_297.t0 VPB.t1 sky130_fd_pr__pfet_01v8_hvt ad=0.1475 pd=1.295 as=0.14 ps=1.28 w=1 l=0.15
X4 a_113_297.t2 B1.t1 Y.t2 VPB.t0 sky130_fd_pr__pfet_01v8_hvt ad=0.14 pd=1.28 as=0.265 ps=2.53 w=1 l=0.15
X5 VGND.t0 A2.t0 a_199_47.t1 VNB.t2 sky130_fd_pr__nfet_01v8 ad=0.17225 pd=1.83 as=0.09588 ps=0.945 w=0.65 l=0.15
R0 a_199_47.t0 a_199_47.t1 54.462
R1 a_113_297.t0 a_113_297.t1 1104.9
R2 a_113_297.t0 a_113_297.t2 56.5726
R3 a_113_297.t1 a_113_297.t2 1104.9
R4 Y Y.t2 362.128
R5 Y.t0 Y.t1 54.1643
R6 Y.t0 Y 566.426
R7 Y.t1 Y 566.426
R8 VPWR.t1 VPWR.t0 59.4849
R9 VPWR.t1 VPWR 1326.35
R10 VPWR.t0 VPWR 1198
R11 VPB.t1 VPB.t2 263.397
R12 VPB.t0 VPB.t1 254.518
R13 VPB VPB.t0 204.207
R14 VNB.t1 VNB.t2 1267.31
R15 VNB.t0 VNB.t1 1224.6
R16 VNB VNB.t0 982.524
R17 VGND VGND.t1 288
R18 VGND VGND.t0 240.708
R19 B1.t1 B1.t0 618.97
R20 B1.t1 B1 610.553
R21 B1.t0 B1 418.099
R22 A2.t1 A2.t0 627.226
R23 A2.t1 A2 610.117
R24 A2.t0 A2 419.171
R25 A1.t1 A1.t0 671.706
R26 A1.t1 A1 621.77
R27 A1.t0 A1 435.652
C0 a_199_47.t1 a_113_297.t1 0
C1 a_199_47.t1 A1 0.00902f
C2 a_199_47.t1 Y 0.00136f
C3 a_199_47.t1 VPWR 0
C4 a_199_47.t1 VGND 0.00451f
C5 a_113_297.t1 VPB 0.00949f
C6 a_113_297.t1 B1 0.0067f
C7 a_113_297.t1 A1 0.04909f
C8 a_113_297.t1 A2 0.04594f
C9 a_113_297.t1 Y 0.09335f
C10 a_113_297.t1 VPWR 0.17835f
C11 a_113_297.t1 VGND 0.00751f
C12 VPB B1 0.03395f
C13 VPB A1 0.02327f
C14 VPB A2 0.03259f
C15 VPB Y 0.01298f
C16 VPB VPWR 0.04264f
C17 VPB VGND 0.00485f
C18 B1 A1 0.04558f
C19 B1 Y 0.11333f
C20 B1 VPWR 0.01217f
C21 B1 VGND 0.04166f
C22 A1 A2 0.08579f
C23 A1 Y 0.08135f
C24 A1 VPWR 0.01384f
C25 A1 VGND 0.07569f
C26 A2 Y 0.00106f
C27 A2 VPWR 0.01324f
C28 A2 VGND 0.04805f
C29 Y VPWR 0.04368f
C30 Y VGND 0.06403f
C31 VPWR VGND 0.03715f
C32 VGND VNB 0.20607f
C33 VPWR VNB 0.14801f
C34 Y VNB 0.02577f
C35 A2 VNB 0.03017f
C36 A1 VNB 0.02806f
C37 B1 VNB 0.04243f
C38 VPB VNB 0.09774f
C39 A1.t1 VNB 0.01591f
C40 A1.t0 VNB 0.01378f
C41 A2.t1 VNB 0.03508f
C42 A2.t0 VNB 0.03195f
C43 B1.t1 VNB 0.03683f
C44 B1.t0 VNB 0.03394f
C45 VGND.t0 VNB 0.02473f
C46 VGND.t1 VNB 0.02212f
C47 VPB.t2 VNB 0.17093f
C48 VPB.t1 VNB 0.08426f
C49 VPB.t0 VNB 0.07463f
C50 VPWR.t1 VNB 0.01714f
C51 VPWR.t0 VNB 0.01715f
C52 Y.t2 VNB 0.01028f
C53 Y.t0 VNB 0.00561f
C54 Y.t1 VNB 0.00561f
C55 a_113_297.t1 VNB 0.01573f
C56 a_113_297.t2 VNB 0.00682f
C57 a_113_297.t0 VNB 0.00682f
.ends
