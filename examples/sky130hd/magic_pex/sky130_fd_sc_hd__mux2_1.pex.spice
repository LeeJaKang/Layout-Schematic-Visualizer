* NGSPICE file created from sky130_fd_sc_hd__mux2_1.ext - technology: sky130A

.subckt sky130_fd_sc_hd__mux2_1 VGND VPWR VPB VNB X A1 S A0
X0 VPWR.t2 a_505_21.t3 a_535_374.t1 VPB.t4 sky130_fd_pr__pfet_01v8_hvt ad=0.0693 pd=0.75 as=0.0441 ps=0.63 w=0.42 l=0.15
X1 a_505_21.t1 S.t3 VPWR.t1 VPB.t5 sky130_fd_pr__pfet_01v8_hvt ad=0.1176 pd=1.4 as=0.0693 ps=0.75 w=0.42 l=0.15
X2 a_218_374.t1 S.t1 VPWR.t0 VPB.t1 sky130_fd_pr__pfet_01v8_hvt ad=0.07665 pd=0.785 as=0.15835 ps=1.395 w=0.42 l=0.15
X3 VGND.t2 a_505_21.t2 a_439_47.t1 VNB.t4 sky130_fd_pr__nfet_01v8 ad=0.1449 pd=1.11 as=0.0693 ps=0.75 w=0.42 l=0.15
X4 a_76_199.t0 A0.t0 a_218_374.t0 VPB.t2 sky130_fd_pr__pfet_01v8_hvt ad=0.1932 pd=1.34 as=0.07665 ps=0.785 w=0.42 l=0.15
X5 a_505_21.t0 S.t2 VGND.t1 VNB.t5 sky130_fd_pr__nfet_01v8 ad=0.1092 pd=1.36 as=0.1449 ps=1.11 w=0.42 l=0.15
X6 a_439_47.t0 A0.t1 a_76_199.t1 VNB.t3 sky130_fd_pr__nfet_01v8 ad=0.0693 pd=0.75 as=0.09975 ps=0.895 w=0.42 l=0.15
X7 a_535_374.t0 A1.t1 a_76_199.t3 VPB.t3 sky130_fd_pr__pfet_01v8_hvt ad=0.0441 pd=0.63 as=0.1932 ps=1.34 w=0.42 l=0.15
X8 a_76_199.t2 A1.t0 a_218_47.t0 VNB.t2 sky130_fd_pr__nfet_01v8 ad=0.09975 pd=0.895 as=0.0693 ps=0.75 w=0.42 l=0.15
X9 a_218_47.t1 S.t0 VGND.t0 VNB.t1 sky130_fd_pr__nfet_01v8 ad=0.0693 pd=0.75 as=0.11285 ps=1.045 w=0.42 l=0.15
X10 VPWR.t3 a_76_199.t5 X.t1 VPB.t0 sky130_fd_pr__pfet_01v8_hvt ad=0.15835 pd=1.395 as=0.26 ps=2.52 w=1 l=0.15
X11 VGND.t3 a_76_199.t4 X.t0 VNB.t0 sky130_fd_pr__nfet_01v8 ad=0.11285 pd=1.045 as=0.169 ps=1.82 w=0.65 l=0.15
R0 a_76_199.t5 a_76_199.t4 593.639
R1 a_76_199.t5 a_76_199.n0 784.091
R2 a_76_199.t4 a_76_199.n0 549.385
R3 a_76_199.t1 a_76_199.t2 154.639
R4 a_76_199.t1 a_76_199.n0 770.431
R5 a_76_199.t2 a_76_199.n0 338.522
R6 a_76_199.t0 a_76_199.n0 938.105
R7 a_76_199.t0 a_76_199.t3 515.986
R8 a_76_199.n0 a_76_199.t3 1034.72
R9 a_535_374.t0 a_535_374.t1 98.5005
R10 a_505_21.n0 a_505_21.t1 703.471
R11 a_505_21.t0 a_505_21.n0 246.56
R12 a_505_21.t3 a_505_21.t2 881.491
R13 a_505_21.t3 a_505_21.n0 849.837
R14 a_505_21.t2 a_505_21.n0 540.087
R15 a_439_47.t0 a_439_47.t1 94.2862
R16 a_218_47.t0 a_218_47.t1 94.2862
R17 a_218_374.t0 a_218_374.t1 171.202
R18 X.t1 X 223.393
R19 X X.t0 212.403
R20 VPWR.t1 VPWR.t2 163.966
R21 VPWR.t1 VPWR 1214.79
R22 VPWR.t2 VPWR 1549.9
R23 VPWR VPWR.t0 1406.25
R24 VPWR VPWR.t3 327.368
R25 VPWR.t0 VPWR.t3 166.917
R26 VPB.t2 VPB.t3 633.333
R27 VPB.t0 VPB.t1 322.587
R28 VPB.t1 VPB.t2 304.829
R29 VPB.t4 VPB.t5 284.113
R30 VPB.t3 VPB.t4 213.084
R31 VPB VPB.t0 59.1905
R32 VNB.t4 VNB.t5 2392.23
R33 VNB.t2 VNB.t3 1779.94
R34 VNB.t0 VNB.t1 1552.1
R35 VNB.t3 VNB.t4 1366.99
R36 VNB.t1 VNB.t2 1366.99
R37 VNB VNB.t0 142.395
R38 VGND.t2 VGND 281.745
R39 VGND VGND.t0 880.176
R40 VGND VGND.t3 301.291
R41 VGND.t0 VGND.t3 108.906
R42 VGND.t2 VGND.t1 274.565
R43 VGND VGND.t1 217.725
R44 S.t3 S.t2 798.808
R45 S.t3 S 369.676
R46 S.t2 S 822.096
R47 S.t1 S.t0 609.316
R48 S.t1 S 1264.81
R49 S.t0 S 958.567
R50 A1.t0 A1 484.974
R51 A1.t0 A1.t1 4914
R52 A1 A1.t1 351.474
R53 A0.t0 A0.t1 1073.35
R54 A0.t0 A0 1114.93
R55 A0.t1 A0 350.952
C0 a_76_199.n0 a_535_374.t1 0
C1 a_76_199.n0 a_218_47.t1 0.00745f
C2 a_76_199.n0 a_218_374.t1 0.0053f
C3 a_76_199.n0 VPB 0.04427f
C4 a_76_199.n0 X 0.07778f
C5 a_76_199.n0 VPWR 0.05255f
C6 a_76_199.n0 S 0.32036f
C7 a_76_199.n0 A0 0.05275f
C8 a_76_199.n0 A1 0.19355f
C9 a_76_199.n0 VGND 0.15603f
C10 a_535_374.t1 VPWR 0
C11 a_535_374.t1 S 0.00499f
C12 a_535_374.t1 VGND 0
C13 a_505_21.n0 VPB 0.07027f
C14 a_505_21.n0 VPWR 0.07887f
C15 a_505_21.n0 S 0.17943f
C16 a_505_21.n0 A0 0.03271f
C17 a_505_21.n0 A1 0.09173f
C18 a_505_21.n0 VGND 0.11838f
C19 a_439_47.t1 VPWR 0
C20 a_439_47.t1 A0 0.00351f
C21 a_439_47.t1 A1 0.00471f
C22 a_439_47.t1 VGND 0.00327f
C23 a_218_47.t1 X 0
C24 a_218_47.t1 VPWR 0
C25 a_218_47.t1 VGND 0.00445f
C26 a_218_374.t1 VPWR 0.00163f
C27 a_218_374.t1 S 0.00623f
C28 a_218_374.t1 VGND 0
C29 VPB X 0.01075f
C30 VPB VPWR 0.1174f
C31 VPB S 0.15203f
C32 VPB A0 0.09392f
C33 VPB A1 0.06472f
C34 VPB VGND 0.01195f
C35 X VPWR 0.13336f
C36 X S 0.00737f
C37 X VGND 0.06043f
C38 VPWR S 0.40969f
C39 VPWR A0 0.00679f
C40 VPWR A1 0.01035f
C41 VPWR VGND 0.08142f
C42 S A0 0.02812f
C43 S A1 0.08075f
C44 S VGND 0.0355f
C45 A0 A1 0.2631f
C46 A0 VGND 0.04423f
C47 A1 VGND 0.07475f
C48 VGND VNB 0.37854f
C49 A1 VNB 0.05276f
C50 A0 VNB 0.0455f
C51 S VNB 0.08134f
C52 VPWR VNB 0.30506f
C53 X VNB 0.04817f
C54 VPB VNB 0.11749f
C55 A0.t0 VNB 0.02296f
C56 A0.t1 VNB 0.02044f
C57 A1.t0 VNB 0.02448f
C58 A1.t1 VNB 0.01667f
C59 S.t3 VNB 0.01719f
C60 S.t2 VNB 0.01744f
C61 S.t1 VNB 0.02745f
C62 S.t0 VNB 0.03058f
C63 VGND.t1 VNB 0.01639f
C64 VGND.t2 VNB 0.01622f
C65 VGND.t0 VNB 0.0106f
C66 VGND.t3 VNB 0.0172f
C67 VPB.t5 VNB 0.21764f
C68 VPB.t4 VNB 0.08089f
C69 VPB.t3 VNB 0.13771f
C70 VPB.t2 VNB 0.15263f
C71 VPB.t1 VNB 0.10208f
C72 VPB.t0 VNB 0.06211f
C73 VPWR.t1 VNB 0.00743f
C74 VPWR.t2 VNB 0.00735f
C75 VPWR.t0 VNB 0.01044f
C76 VPWR.t3 VNB 0.02251f
C77 X.t1 VNB 0.01866f
C78 X.t0 VNB 0.01216f
C79 a_505_21.t1 VNB 0.01715f
C80 a_505_21.t3 VNB 0.02261f
C81 a_505_21.t2 VNB 0.02354f
C82 a_505_21.n0 VNB 0.11038f
C83 a_505_21.t0 VNB 0.01301f
C84 a_76_199.t5 VNB 0.01033f
C85 a_76_199.t4 VNB 0.00946f
C86 a_76_199.t1 VNB 0.0049f
C87 a_76_199.t2 VNB 0.00492f
C88 a_76_199.n0 VNB 0.04097f
C89 a_76_199.t3 VNB 0.01022f
C90 a_76_199.t0 VNB 0.01028f
.ends
