* NGSPICE file created from sky130_fd_sc_hd__fa_1.ext - technology: sky130A

.subckt sky130_fd_sc_hd__fa_1 VPB VNB VGND VPWR B COUT A CIN SUM
X0 a_76_199.t0 B.t0 a_208_47.t1 VNB.t2 sky130_fd_pr__nfet_01v8 ad=0.0567 pd=0.69 as=0.063 ps=0.72 w=0.42 l=0.15
X1 VGND.t1 A.t2 a_382_47.t0 VNB.t4 sky130_fd_pr__nfet_01v8 ad=0.0567 pd=0.69 as=0.0567 ps=0.69 w=0.42 l=0.15
X2 a_738_413.t0 A.t5 VPWR.t2 VPB.t8 sky130_fd_pr__pfet_01v8_hvt ad=0.06195 pd=0.715 as=0.0567 ps=0.69 w=0.42 l=0.15
X3 a_1091_47.t1 CIN.t4 a_995_47.t0 VNB.t10 sky130_fd_pr__nfet_01v8 ad=0.0441 pd=0.63 as=0.0693 ps=0.75 w=0.42 l=0.15
X4 VPWR.t6 CIN.t3 a_738_413.t2 VPB.t7 sky130_fd_pr__pfet_01v8_hvt ad=0.0567 pd=0.69 as=0.0567 ps=0.69 w=0.42 l=0.15
X5 a_382_413.t1 B.t3 VPWR.t4 VPB.t5 sky130_fd_pr__pfet_01v8_hvt ad=0.1092 pd=1.36 as=0.0567 ps=0.69 w=0.42 l=0.15
X6 a_1163_47.t1 B.t6 a_1091_47.t0 VNB.t11 sky130_fd_pr__nfet_01v8 ad=0.0693 pd=0.75 as=0.0441 ps=0.63 w=0.42 l=0.15
X7 VPWR.t1 A.t3 a_382_413.t0 VPB.t4 sky130_fd_pr__pfet_01v8_hvt ad=0.0567 pd=0.69 as=0.0567 ps=0.69 w=0.42 l=0.15
X8 a_995_47.t2 a_76_199.t6 a_738_47.t3 VNB.t9 sky130_fd_pr__nfet_01v8 ad=0.0693 pd=0.75 as=0.06195 ps=0.715 w=0.42 l=0.15
X9 a_382_413.t2 CIN.t1 a_76_199.t3 VPB.t3 sky130_fd_pr__pfet_01v8_hvt ad=0.0567 pd=0.69 as=0.0567 ps=0.69 w=0.42 l=0.15
X10 SUM.t0 a_995_47.t4 VGND.t8 VNB.t13 sky130_fd_pr__nfet_01v8 ad=0.169 pd=1.82 as=0.10235 ps=0.995 w=0.65 l=0.15
X11 a_208_47.t0 A.t0 VGND.t0 VNB.t1 sky130_fd_pr__nfet_01v8 ad=0.063 pd=0.72 as=0.10235 ps=0.995 w=0.42 l=0.15
X12 VGND.t6 CIN.t2 a_738_47.t2 VNB.t7 sky130_fd_pr__nfet_01v8 ad=0.0567 pd=0.69 as=0.0567 ps=0.69 w=0.42 l=0.15
X13 a_76_199.t1 B.t1 a_208_413.t1 VPB.t2 sky130_fd_pr__pfet_01v8_hvt ad=0.0567 pd=0.69 as=0.063 ps=0.72 w=0.42 l=0.15
X14 a_208_413.t0 A.t1 VPWR.t0 VPB.t1 sky130_fd_pr__pfet_01v8_hvt ad=0.063 pd=0.72 as=0.14785 ps=1.345 w=0.42 l=0.15
X15 a_738_413.t1 B.t5 VPWR.t5 VPB.t6 sky130_fd_pr__pfet_01v8_hvt ad=0.0567 pd=0.69 as=0.1092 ps=1.36 w=0.42 l=0.15
X16 VGND.t3 A.t6 a_1163_47.t0 VNB.t12 sky130_fd_pr__nfet_01v8 ad=0.10235 pd=0.995 as=0.0693 ps=0.75 w=0.42 l=0.15
X17 a_738_47.t1 B.t4 VGND.t5 VNB.t6 sky130_fd_pr__nfet_01v8 ad=0.0567 pd=0.69 as=0.1092 ps=1.36 w=0.42 l=0.15
X18 a_738_47.t0 A.t4 VGND.t2 VNB.t8 sky130_fd_pr__nfet_01v8 ad=0.06195 pd=0.715 as=0.0567 ps=0.69 w=0.42 l=0.15
X19 a_1163_413.t1 B.t7 a_1091_413.t0 VPB.t11 sky130_fd_pr__pfet_01v8_hvt ad=0.0693 pd=0.75 as=0.0441 ps=0.63 w=0.42 l=0.15
X20 VPWR.t3 A.t7 a_1163_413.t0 VPB.t12 sky130_fd_pr__pfet_01v8_hvt ad=0.14785 pd=1.345 as=0.0693 ps=0.75 w=0.42 l=0.15
X21 a_382_47.t2 CIN.t0 a_76_199.t2 VNB.t3 sky130_fd_pr__nfet_01v8 ad=0.0567 pd=0.69 as=0.0567 ps=0.69 w=0.42 l=0.15
X22 a_382_47.t1 B.t2 VGND.t4 VNB.t5 sky130_fd_pr__nfet_01v8 ad=0.1092 pd=1.36 as=0.0567 ps=0.69 w=0.42 l=0.15
X23 SUM.t1 a_995_47.t5 VPWR.t8 VPB.t13 sky130_fd_pr__pfet_01v8_hvt ad=0.26 pd=2.52 as=0.14785 ps=1.345 w=1 l=0.15
X24 a_995_47.t3 a_76_199.t7 a_738_413.t3 VPB.t9 sky130_fd_pr__pfet_01v8_hvt ad=0.0693 pd=0.75 as=0.06195 ps=0.715 w=0.42 l=0.15
X25 VPWR.t7 a_76_199.t5 COUT.t1 VPB.t0 sky130_fd_pr__pfet_01v8_hvt ad=0.14785 pd=1.345 as=0.26 ps=2.52 w=1 l=0.15
X26 a_1091_413.t1 CIN.t5 a_995_47.t1 VPB.t10 sky130_fd_pr__pfet_01v8_hvt ad=0.0441 pd=0.63 as=0.0693 ps=0.75 w=0.42 l=0.15
X27 VGND.t7 a_76_199.t4 COUT.t0 VNB.t0 sky130_fd_pr__nfet_01v8 ad=0.10235 pd=0.995 as=0.169 ps=1.82 w=0.65 l=0.15
R0 a_995_47.t1 a_995_47.t3 162.911
R1 a_995_47.t1 a_995_47.n0 1269.55
R2 a_995_47.t3 a_995_47.n0 1833.8
R3 a_995_47.t5 a_995_47.t4 679.696
R4 a_995_47.t5 a_995_47.n0 610.472
R5 a_995_47.t4 a_995_47.n0 427.738
R6 a_995_47.t0 a_995_47.t2 101.364
R7 a_995_47.t0 a_995_47.n0 552.424
R8 a_995_47.t2 a_995_47.n0 797.947
R9 a_76_199.n1 a_76_199.n0 72.1596
R10 a_76_199.t7 a_76_199.t6 871.944
R11 a_76_199.t7 a_76_199.n1 983.23
R12 a_76_199.t6 a_76_199.n1 441.536
R13 a_76_199.t3 a_76_199.t1 132.708
R14 a_76_199.t3 a_76_199.n0 1385.45
R15 a_76_199.t1 a_76_199.n0 1385.45
R16 a_76_199.t5 a_76_199.t4 679.696
R17 a_76_199.t5 a_76_199.n0 610.472
R18 a_76_199.t4 a_76_199.n0 427.738
R19 a_76_199.t2 a_76_199.t0 85.15
R20 a_76_199.t2 a_76_199.n1 410.202
R21 a_76_199.t0 a_76_199.n1 410.202
R22 a_738_47.n0 a_738_47.t3 45.7148
R23 a_738_47.t0 a_738_47.n0 38.5719
R24 a_738_47.t2 a_738_47.t1 80.3857
R25 a_738_47.t2 a_738_47.n0 956.266
R26 a_738_47.t1 a_738_47.n0 956.266
R27 a_738_413.n0 a_738_413.t3 75.0481
R28 a_738_413.t0 a_738_413.n0 63.3219
R29 a_738_413.t2 a_738_413.t1 129.828
R30 a_738_413.t2 a_738_413.n0 2581.02
R31 a_738_413.t1 a_738_413.n0 2581.02
R32 a_382_47.t0 a_382_47.t2 80.1343
R33 a_382_47.t0 a_382_47.t1 1033.41
R34 a_382_47.t2 a_382_47.t1 1033.41
R35 a_382_413.t0 a_382_413.t2 129.689
R36 a_382_413.t0 a_382_413.t1 2697.04
R37 a_382_413.t2 a_382_413.t1 2697.04
R38 a_208_47.t0 a_208_47.t1 85.7148
R39 a_208_413.t0 a_208_413.t1 140.714
R40 a_1163_47.t0 a_1163_47.t1 94.2862
R41 a_1163_413.t0 a_1163_413.t1 154.786
R42 a_1091_47.t0 a_1091_47.t1 60.0005
R43 a_1091_413.t0 a_1091_413.t1 98.5005
R44 VPWR.n1 VPWR.t5 663.062
R45 VPWR.n0 VPWR.t6 63.3219
R46 VPWR.n0 VPWR.t2 63.3219
R47 VPWR.n0 VPWR.n1 2952.26
R48 VPWR.n0 VPWR 761.354
R49 VPWR.n1 VPWR 6.36907
R50 VPWR VPWR.t0 2863.13
R51 VPWR VPWR.t7 812.582
R52 VPWR.t0 VPWR.t7 130.962
R53 VPWR.t4 VPWR.t1 133.275
R54 VPWR.t8 VPWR.t3 131.008
R55 VPWR.t8 VPWR 804.385
R56 VPWR.t3 VPWR 2834.24
R57 VPWR.t1 VPWR.n1 22789.6
R58 VPWR.t1 VPWR 1347.76
R59 VPWR.t4 VPWR.n1 22789.6
R60 VPWR.t4 VPWR 1347.76
R61 VPB.t5 VPB.t6 556.386
R62 VPB.t0 VPB.t1 292.991
R63 VPB.t12 VPB.t13 292.991
R64 VPB.t9 VPB.t10 284.113
R65 VPB.t11 VPB.t12 284.113
R66 VPB.t1 VPB.t2 266.356
R67 VPB.t8 VPB.t9 263.397
R68 VPB.t2 VPB.t3 248.599
R69 VPB.t3 VPB.t4 248.599
R70 VPB.t4 VPB.t5 248.599
R71 VPB.t6 VPB.t7 248.599
R72 VPB.t7 VPB.t8 248.599
R73 VPB.t10 VPB.t11 213.084
R74 VPB VPB.t0 189.409
R75 VNB.t5 VNB.t6 2677.02
R76 VNB.t0 VNB.t1 1409.71
R77 VNB.t12 VNB.t13 1409.71
R78 VNB.t9 VNB.t10 1366.99
R79 VNB.t11 VNB.t12 1366.99
R80 VNB.t1 VNB.t2 1281.55
R81 VNB.t8 VNB.t9 1267.31
R82 VNB.t2 VNB.t3 1196.12
R83 VNB.t3 VNB.t4 1196.12
R84 VNB.t4 VNB.t5 1196.12
R85 VNB.t6 VNB.t7 1196.12
R86 VNB.t7 VNB.t8 1196.12
R87 VNB.t10 VNB.t11 1025.24
R88 VNB VNB.t0 911.327
R89 VGND.n1 VGND.t5 239.281
R90 VGND.n0 VGND.t6 38.5719
R91 VGND.n0 VGND.t2 38.5719
R92 VGND.n0 VGND.n1 996.153
R93 VGND.n0 VGND 258.546
R94 VGND.n1 VGND 6.40327
R95 VGND VGND.t0 749.559
R96 VGND VGND.t7 317.671
R97 VGND.t0 VGND.t7 92.8624
R98 VGND.t4 VGND.t1 84.4152
R99 VGND.t8 VGND.t3 94.2171
R100 VGND.t8 VGND 502.356
R101 VGND.t3 VGND 413.524
R102 VGND.t1 VGND.n1 8019.58
R103 VGND.t1 VGND 474.231
R104 VGND.t4 VGND.n1 8019.58
R105 VGND.t4 VGND 474.231
R106 SUM SUM.t1 378.42
R107 SUM SUM.t0 212.529
R108 COUT COUT.t1 382.693
R109 COUT COUT.t0 216.446
R110 CIN.n1 CIN.n0 88.4259
R111 CIN CIN.n1 5.3765
R112 CIN.t1 CIN.t0 737.202
R113 CIN.t1 CIN.n0 1220.9
R114 CIN.t0 CIN.n0 810.582
R115 CIN.t3 CIN.t2 979.476
R116 CIN.t3 CIN.n0 430.264
R117 CIN.t2 CIN.n0 770.062
R118 CIN.t5 CIN.t4 952.576
R119 CIN.t5 CIN.n1 387.887
R120 CIN.t4 CIN.n1 863.761
R121 B.n1 B.n0 163.79
R122 B.n2 B.n1 10.8599
R123 B B.n2 2.7205
R124 B.t1 B.t0 921.697
R125 B.t1 B.n2 378.526
R126 B.t0 B.n2 930.76
R127 B.t7 B.t6 913.76
R128 B.t7 B.n1 410.817
R129 B.t6 B.n1 914.822
R130 B.t3 B.t5 1043.01
R131 B.t3 B.n0 482.055
R132 B.t5 B.n0 166.494
R133 B.t2 B.n0 1256.84
R134 B.t2 B.t4 640.342
R135 B.n0 B.t4 390.111
R136 A.n2 A.n1 11.595
R137 A A.n2 2.13383
R138 A.n1 A.n0 1.55989
R139 A.t7 A.t6 943.682
R140 A.t7 A.n0 814.362
R141 A.t6 A.n0 452.981
R142 A.t5 A.t4 916.905
R143 A.t5 A.n0 910.293
R144 A.t4 A.n0 408.784
R145 A.t3 A.t2 955.053
R146 A.t3 A.n1 745.967
R147 A.t2 A.n1 501.428
R148 A.t1 A.t0 994.965
R149 A.t1 A.n2 733.476
R150 A.t0 A.n2 451.822
C0 a_995_47.n0 a_76_199.n1 0.04894f
C1 a_995_47.n0 a_738_47.n0 0.02125f
C2 a_995_47.n0 a_738_413.n0 0.0211f
C3 a_995_47.n0 a_1163_47.t1 0.00777f
C4 a_995_47.n0 a_1163_413.t1 0.00762f
C5 a_995_47.n0 a_1091_47.t1 0.00537f
C6 a_995_47.n0 a_1091_413.t1 0.00485f
C7 a_995_47.n0 VPB 0.04658f
C8 a_995_47.n0 A 0.14987f
C9 a_995_47.n0 B 0.07381f
C10 a_995_47.n0 CIN 0.04887f
C11 a_995_47.n0 VPWR 0.21853f
C12 a_995_47.n0 VGND 0.20453f
C13 a_995_47.n0 SUM 0.14833f
C14 a_76_199.n1 a_738_47.n0 0.03564f
C15 a_76_199.n1 a_738_413.n0 0.00465f
C16 a_76_199.n1 a_382_47.t1 0.06396f
C17 a_76_199.n1 a_382_413.t1 0.02898f
C18 a_76_199.n1 a_208_47.t1 0.00688f
C19 a_76_199.n1 a_208_413.t1 0.00693f
C20 a_76_199.n1 a_1091_47.t1 0
C21 a_76_199.n1 a_1091_413.t1 0
C22 a_76_199.n1 VPB 0.09401f
C23 a_76_199.n1 A 0.70673f
C24 a_76_199.n1 B 0.12564f
C25 a_76_199.n1 CIN 0.19582f
C26 a_76_199.n1 COUT 0.13344f
C27 a_76_199.n1 VPWR 0.1924f
C28 a_76_199.n1 VGND 0.41664f
C29 a_76_199.n1 SUM 0
C30 a_738_47.n0 a_382_47.t1 0.00689f
C31 a_738_47.n0 a_1163_47.t1 0
C32 a_738_47.n0 a_1091_47.t1 0
C33 a_738_47.n0 VPB 0
C34 a_738_47.n0 A 0.04694f
C35 a_738_47.n0 B 0.00602f
C36 a_738_47.n0 CIN 0.04364f
C37 a_738_47.n0 VGND 0.15221f
C38 a_738_413.n0 a_382_413.t1 0.008f
C39 a_738_413.n0 a_1163_413.t1 0
C40 a_738_413.n0 a_1091_413.t1 0
C41 a_738_413.n0 VPB 0.014f
C42 a_738_413.n0 A 0.01219f
C43 a_738_413.n0 B 0.01717f
C44 a_738_413.n0 CIN 0.07731f
C45 a_738_413.n0 VPWR 0.1503f
C46 a_382_47.t1 VPB 0.0012f
C47 a_382_47.t1 A 0.03978f
C48 a_382_47.t1 B 0.0179f
C49 a_382_47.t1 CIN 0.03242f
C50 a_382_47.t1 VGND 0.14475f
C51 a_382_413.t1 VPB 0.01333f
C52 a_382_413.t1 A 0.01166f
C53 a_382_413.t1 B 0.03168f
C54 a_382_413.t1 CIN 0.09461f
C55 a_382_413.t1 VPWR 0.15421f
C56 a_208_47.t1 A 0
C57 a_208_47.t1 COUT 0
C58 a_208_47.t1 VGND 0.00197f
C59 a_208_413.t1 A 0
C60 a_208_413.t1 VPWR 0
C61 a_1163_47.t1 A 0
C62 a_1163_47.t1 B 0
C63 a_1163_47.t1 VGND 0.0018f
C64 a_1163_47.t1 SUM 0
C65 a_1163_413.t1 A 0
C66 a_1163_413.t1 B 0
C67 a_1163_413.t1 VPWR 0
C68 a_1091_47.t1 A 0
C69 a_1091_47.t1 B 0
C70 a_1091_47.t1 VGND 0
C71 a_1091_413.t1 B 0
C72 a_1091_413.t1 VPWR 0
C73 VPB A 0.24727f
C74 VPB B 0.30494f
C75 VPB CIN 0.21144f
C76 VPB COUT 0.01078f
C77 VPB VPWR 0.16675f
C78 VPB VGND 0.00478f
C79 VPB SUM 0.01877f
C80 A B 0.74022f
C81 A CIN 0.42865f
C82 A COUT 0.00383f
C83 A VPWR 0.07163f
C84 A VGND 0.10303f
C85 A SUM 0.00605f
C86 B CIN 0.57825f
C87 B COUT 0
C88 B VPWR 0.25134f
C89 B VGND 0.04435f
C90 B SUM 0.00101f
C91 CIN VPWR 0.05152f
C92 CIN VGND 0.05377f
C93 COUT VPWR 0.06832f
C94 COUT VGND 0.05835f
C95 VPWR VGND 0.04231f
C96 VPWR SUM 0.07709f
C97 VGND SUM 0.07237f
C98 SUM VNB 0.05954f
C99 VGND VNB 0.58529f
C100 VPWR VNB 0.4541f
C101 COUT VNB 0.04785f
C102 CIN VNB 0.00461f
C103 B VNB 0.00172f
C104 A VNB 0.00481f
C105 VPB VNB 0.0963f
C106 A.t7 VNB 0.01836f
C107 A.t6 VNB 0.01802f
C108 A.t5 VNB 0.01849f
C109 A.t4 VNB 0.01814f
C110 A.n0 VNB 0.08784f
C111 A.t3 VNB 0.01825f
C112 A.t2 VNB 0.01799f
C113 A.n1 VNB 0.0624f
C114 A.t1 VNB 0.01787f
C115 A.t0 VNB 0.0173f
C116 A.n2 VNB 0.01583f
C117 B.t1 VNB 0.01708f
C118 B.t0 VNB 0.01759f
C119 B.t7 VNB 0.01755f
C120 B.t6 VNB 0.01777f
C121 B.t3 VNB 0.0147f
C122 B.t5 VNB 0.01269f
C123 B.t2 VNB 0.01747f
C124 B.t4 VNB 0.01796f
C125 B.n0 VNB 0.031f
C126 B.n1 VNB 0.10007f
C127 B.n2 VNB 0.02592f
C128 CIN.t1 VNB 0.02006f
C129 CIN.t0 VNB 0.02278f
C130 CIN.t3 VNB 0.01356f
C131 CIN.t2 VNB 0.01412f
C132 CIN.n0 VNB 0.07158f
C133 CIN.t5 VNB 0.01367f
C134 CIN.t4 VNB 0.01423f
C135 CIN.n1 VNB 0.0185f
C136 COUT.t1 VNB 0.01787f
C137 COUT.t0 VNB 0.01325f
C138 SUM.t1 VNB 0.0143f
C139 SUM.t0 VNB 0.01032f
C140 VGND.t0 VNB 0.00918f
C141 VGND.t7 VNB 0.01496f
C142 VGND.t4 VNB 0.00699f
C143 VGND.t1 VNB 0.00699f
C144 VGND.t5 VNB 0.01189f
C145 VGND.t2 VNB 0.00329f
C146 VGND.t6 VNB 0.00329f
C147 VGND.n0 VNB 0.00821f
C148 VGND.t8 VNB 0.01507f
C149 VGND.t3 VNB 0.00952f
C150 VGND.n1 VNB 0.03894f
C151 VPB.t13 VNB 0.20849f
C152 VPB.t12 VNB 0.09389f
C153 VPB.t11 VNB 0.08089f
C154 VPB.t10 VNB 0.08089f
C155 VPB.t9 VNB 0.08908f
C156 VPB.t8 VNB 0.0833f
C157 VPB.t7 VNB 0.08089f
C158 VPB.t6 VNB 0.13097f
C159 VPB.t5 VNB 0.13097f
C160 VPB.t4 VNB 0.08089f
C161 VPB.t3 VNB 0.08089f
C162 VPB.t2 VNB 0.08378f
C163 VPB.t1 VNB 0.091f
C164 VPB.t0 VNB 0.07848f
C165 VPWR.t0 VNB 0.00741f
C166 VPWR.t7 VNB 0.01905f
C167 VPWR.t4 VNB 0.00515f
C168 VPWR.t1 VNB 0.00515f
C169 VPWR.t5 VNB 0.00929f
C170 VPWR.t2 VNB 0.00254f
C171 VPWR.t6 VNB 0.00254f
C172 VPWR.n0 VNB 0.00551f
C173 VPWR.t8 VNB 0.01906f
C174 VPWR.t3 VNB 0.00741f
C175 VPWR.n1 VNB 0.02943f
C176 a_382_413.t2 VNB 0
C177 a_382_413.t1 VNB 0
C178 a_382_413.t0 VNB 0
C179 a_382_47.t2 VNB 0.0028f
C180 a_382_47.t1 VNB 0.00511f
C181 a_382_47.t0 VNB 0.0028f
C182 a_738_413.t3 VNB 0
C183 a_738_413.t2 VNB 0
C184 a_738_413.t1 VNB 0
C185 a_738_413.n0 VNB 0
C186 a_738_413.t0 VNB 0
C187 a_738_47.t3 VNB 0
C188 a_738_47.t2 VNB 0.00244f
C189 a_738_47.t1 VNB 0.00244f
C190 a_738_47.n0 VNB 0.00421f
C191 a_738_47.t0 VNB 0
C192 a_76_199.t2 VNB 0.0033f
C193 a_76_199.t7 VNB 0.01155f
C194 a_76_199.t6 VNB 0.01245f
C195 a_76_199.t3 VNB 0.00471f
C196 a_76_199.t1 VNB 0.00471f
C197 a_76_199.t5 VNB 0.01164f
C198 a_76_199.t4 VNB 0.01005f
C199 a_76_199.n0 VNB 0.04658f
C200 a_76_199.n1 VNB 0.07629f
C201 a_76_199.t0 VNB 0.0033f
C202 a_995_47.t2 VNB 0.00536f
C203 a_995_47.t1 VNB 0.00529f
C204 a_995_47.t3 VNB 0.0047f
C205 a_995_47.t5 VNB 0.00928f
C206 a_995_47.t4 VNB 0.00801f
C207 a_995_47.n0 VNB 0.04916f
C208 a_995_47.t0 VNB 0.00624f
.ends
