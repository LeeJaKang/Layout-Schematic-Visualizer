* NGSPICE file created from sky130_fd_sc_hd__nand2_1.ext - technology: sky130A

.subckt sky130_fd_sc_hd__nand2_1 VPB VNB VGND VPWR A Y B
X0 VPWR.t0 A.t1 Y.t1 VPB.t1 sky130_fd_pr__pfet_01v8_hvt ad=0.26 pd=2.52 as=0.135 ps=1.27 w=1 l=0.15
X1 Y.t0 A.t0 a_113_47.t0 VNB.t1 sky130_fd_pr__nfet_01v8 ad=0.169 pd=1.82 as=0.08775 ps=0.92 w=0.65 l=0.15
X2 a_113_47.t1 B.t0 VGND.t0 VNB.t0 sky130_fd_pr__nfet_01v8 ad=0.08775 pd=0.92 as=0.169 ps=1.82 w=0.65 l=0.15
X3 Y.t2 B.t1 VPWR.t1 VPB.t0 sky130_fd_pr__pfet_01v8_hvt ad=0.135 pd=1.27 as=0.26 ps=2.52 w=1 l=0.15
R0 a_113_47.t0 a_113_47.t1 49.8467
R1 Y Y.t0 141.863
R2 Y.t1 Y 501.75
R3 Y.t1 Y.t2 56.1676
R4 Y Y.t2 501.75
R5 VPWR VPWR.t0 256.344
R6 VPWR VPWR.t1 254.13
R7 VPB.t0 VPB.t1 248.599
R8 VPB VPB.t0 207.166
R9 VNB.t0 VNB.t1 1196.12
R10 VNB VNB.t0 996.764
R11 VGND VGND.t0 158.046
R12 B.t1 B.t0 614.563
R13 B.t1 B 617.915
R14 B.t0 B 423.142
R15 A.t1 A.t0 623.771
R16 A.t1 A 608.939
R17 A.t0 A 417.649
C0 a_113_47.t1 VPWR 0
C1 a_113_47.t1 Y 0.00941f
C2 a_113_47.t1 VGND 0.00182f
C3 VPB B 0.03413f
C4 VPB A 0.0331f
C5 VPB VPWR 0.05131f
C6 VPB Y 0.00548f
C7 VPB VGND 0.00389f
C8 B A 0.0445f
C9 B VPWR 0.04982f
C10 B Y 0.0465f
C11 B VGND 0.05296f
C12 A VPWR 0.04628f
C13 A Y 0.08432f
C14 A VGND 0.00873f
C15 VPWR Y 0.22134f
C16 VPWR VGND 0.03166f
C17 Y VGND 0.14093f
C18 VGND VNB 0.17714f
C19 Y VNB 0.03089f
C20 VPWR VNB 0.15229f
C21 A VNB 0.02842f
C22 B VNB 0.02966f
C23 VPB VNB 0.09726f
C24 A.t1 VNB 0.03558f
C25 A.t0 VNB 0.03259f
C26 B.t1 VNB 0.03606f
C27 B.t0 VNB 0.0333f
C28 VGND.t0 VNB 0.02821f
C29 VPB.t1 VNB 0.16756f
C30 VPB.t0 VNB 0.07415f
C31 VPWR.t0 VNB 0.02895f
C32 VPWR.t1 VNB 0.02897f
C33 Y.t1 VNB 0.00597f
C34 Y.t2 VNB 0.00597f
C35 Y.t0 VNB 0.00575f
.ends
